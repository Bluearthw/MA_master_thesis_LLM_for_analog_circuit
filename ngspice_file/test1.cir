* Diode-connected NMOS amplifier

.include "D:\1kulStudy\8MA_Thesis\material\PDK\45nm.sp"

VDD VDD 0 dc 1.0

M0 VDD VDD VOUT1 VSS nmos w=10u L=1u
R0 VOUT1 VSS 10k
C0 VOUT1 VSS 1p

* DC Analysis
.op

*DC sweep
.dc VDD 0.5 1.5 0.1

* AC Analysis
.ac dec 10 100Hz 100Meg

* Transient Analysis
.tran 1ns 100ns

* Print simulation results
.print dc V(VDD) V(VOUT1) ID(M0) VGS(M0)
.print ac V(VOUT1)
.print tran V(VOUT1)

*Options
.options acct
.end
