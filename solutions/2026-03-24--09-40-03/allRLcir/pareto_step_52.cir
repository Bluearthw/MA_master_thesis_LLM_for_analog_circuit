TwoStage_opamp_netlist

.include "ngspice_interface/files/spice_models/p045_TT.sp"

.param wp1=1.0983061e-06 lp1=1.4491506e-07 mp1=15
.param wn1=2.8510833e-06 ln1=1.6595432e-07 mn1=11
.param wn3=1.4615277e-06 ln3=2.0639442e-07 mn3=5
.param wp3=4.3553086e-07 lp3=6.7333e-08 mp3=23
.param wn4=2.6500788e-06 ln4=1.66823e-07 mn4=11
.param wn5=2.392761e-06 ln5=1.4489814e-07 mn5=12
.param cap=1.6466889e-12
.param res=4875.527

.param ibias=30u
.param cload=10p
.param vcm=0.6

.param VDD=1.2

.param trf=0.5u
.param period=10u
.param vhigh=VDD

*    D    G    S   B
mp1 net4 net4 VDD VDD pmos w=wp1 l=lp1 m=mp1
mp2 net5 net4 VDD VDD pmos w=wp1 l=lp1 m=mp1
mn1 net4 net2 net3 net3 nmos w=wn1 l=ln1 m=mn1
mn2 net5 net1 net3 net3 nmos w=wn1 l=ln1 m=mn1
mn3 net7 net7 VSS VSS nmos w=wn3 l=ln3 m=mn3
mn4 net3 net7 VSS VSS nmos w=wn4 l=ln4 m=mn4
mp3 net6 net5 VDD VDD pmos w=wp3 l=lp3 m=mp3
mn5 net6 net7 VSS VSS nmos w=wn5 l=ln5 m=mn5
cc net5 net8 {cap}
rc net8 net6 {res}

ibias VDD net7 ibias

Vicm VCM VSS dc=vcm
Vinput aid VSS dc=0.0 ac=1.0 PULSE({-VHIGH*0.5} {VHIGH*0.5} trf trf trf {0.5*period-trf} period)
ein1 net1 VCM aid 0 0.5
ein2 net2 VCM aid 0 -0.5

vdd VDD 0 dc=VDD
vss VSS 0 dc=0
CL net6 0 {cload}

.control
run
set units=degrees
set wr_vecnames
option numdgt=7
* set temperature
set temp=25

* transient analysis
tran 50n 30u
* save Vout data in a file named 'tran_TwoStage.csv'
* --- ??? ---
wrdata ./no_backup/output_files/tran_TwoStage.csv v(net6)

* ac analysis
ac dec 10 1 1T
* save Vout data in a file named 'ac_TwoStage.csv'
* --- ??? ---
wrdata ./no_backup/output_files/ac_TwoStage.csv v(net6)

* noise analysis
* calculate the output noise and save it in a file named 'noise_TwoStage.csv'
* --- ??? ---
* --- ??? ---
noise v(net6) Vinput dec 50 1 1e9
wrdata ./no_backup/output_files/noise_TwoStage.csv onoise_total
* dc analysis
save all
op
* save the total current consumption in a file named 'dc_TwoStage.csv'
* --- ??? ---
* dc Vinput 0 0 0.1
wrdata ./no_backup/output_files/dc_TwoStage.csv i(vdd) v(net1) v(net2) v(net3) v(net4) v(net5) v(net6) v(net7) v(net8)

quit
.endc

.end

* /users/micas/mahmadza/public/bin/ngspice /esat/studscratch/r0927410/CAD/CAD/ngspice_interface/files/input_netlists/TwoStage.cir
