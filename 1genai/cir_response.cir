```spice
* Diode-Connected NMOS Stage with AC and DC Sources

.include "1genai/data/45nm.sp"

* Parameters
.param VDD=1.2
.param VSS=0

* DC Source
Vdd VDD 0 dc={VDD}

* AC Source for AC Analysis
Vac VOUT1 0 ac=1

* Components
M0 (VDD VDD VOUT1 VSS) nmos w=500n l=90n
rc (VOUT1 VSS) r=1k
cc (VOUT1 VSS) c=1p

* DC Analysis
.op

* AC Analysis
.ac dec 10 100 10G

* Print AC output voltage
.print ac vdb(VOUT1) vp(VOUT1)

* End
.end
```
