```spice
* Diode-Connected NMOS Stage

.include "./1genai/data/45nm.sp"

* Parameters
.param VDD=1.2
.param VSS=0
.param RVAL=1k
.param CVAL=1p

* Circuit Description
M0 (VDD VDD VOUT1 VSS) nmos w=0.5u l=90n m=1
rc (VOUT1 VSS) {RVAL}
cc (VOUT1 VSS) {CVAL}

* DC Source
vdd VDD 0 dc={VDD}
vss VSS 0 dc={VSS}

* AC Source for AC Analysis
vin VDD 0 ac=1

* Analysis Commands
.control
run

* DC Operating Point Analysis
op

* AC Analysis
ac dec 10 1 100Meg

* Print and Save Results
print dc v(VOUT1) i(vdd)
print ac vdb(VOUT1) vp(VOUT1)

wrdata ./no_backup/output_files/diode_dc.csv v(VOUT1) i(vdd)
wrdata ./no_backup/output_files/diode_ac.csv vdb(VOUT1) vp(VOUT1)

quit
.endc

.end
```
