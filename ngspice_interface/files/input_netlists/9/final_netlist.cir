* title line
.param VB1=0.7
.param VDD=1.2
.param vcm=0.6
.param w0=0.5u
.param l0=90n
.param m0=1
.param w1=0.5u
.param l1=90n
.param m1=1
.param trf=0.5u
.param period=10u
.param Cload=1p
.include "genai_agent/data/p045_TT.sp"
M0 VOUT1 VB1 VDD VDD pmos w=w0 l=l0 m=m0
M1 VOUT1 VIN1 VSS VSS nmos w=w1 l=l1 m=m1
CLOAD VOUT1 VSS {Cload}
vdd VDD 0 dc=VDD
vb1 VB1 0 dc=VB1
vss VSS 0 dc=0
vin VIN1 0 dc=vcm ac=1.0 PULSE(0.5 0.7 {trf} {trf} {trf} {0.5*period-trf} {period})
.control
option numdgt=7
set temp=25
set units=degrees
set wr_vecnames
ac dec 10 1 100G
wrdata ./genai_agent/output/9/ac_gain.csv v(VOUT1)
noise v(VOUT1) vin dec 10 1 100G
wrdata ./genai_agent/output/9/noise.csv inoise_total
tran 10n 20u
wrdata ./genai_agent/output/9/tran_SR.csv v(VOUT1)
alter vdd ac=1.0
alter vin ac=0
ac dec 10 1 100G
wrdata ./genai_agent/output/9/psrr.csv v(VOUT1)
.endc
.end
